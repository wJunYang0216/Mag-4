* Real-device feasibility test - documented alternative MOSFETs
.param RC=11.430016 LC=25.92669m CP=1n RD=10k
VBAT VBAT 0 12
VDD VDD 0 12
VSS VSS 0 -12
VLOG VLOG 0 3.3
M4 TOP G4 VBAT VBAT IRF9640
RCOIL COIL_TOP COILMID {RC}
LCOIL COILMID BOTTOM {LC}
M1 BOTTOM G1 0 0 IRF530
M5 TOP G5 0 0 IRF530
XDRV POL 0 TG 0 DR5 VBAT DR1 VBAT LTC1693-1
XPDRV POL NC2 0 0 NC5 NC6 DR4 VBAT LTC1693-5
RG1 DR1 G1 22
RG4 DR4 G4 22
RG5 DR5 G5 2.2
RGS1 G1 0 100k
RGS4 G4 VBAT 100k
RGS5 G5 0 100k
CBYP VBAT 0 1u
XRX RX PRE BOTTOM VSS 0 VDD FF ADG5412F
XSH SH 0 PRE VSS 0 VDD FF ADG5412F
RDAMP BOTTOM DAMP {RD}
XDP DP 0 DAMP VSS 0 VDD FF ADG5412F
XRESET RESET 0 RX_IN VSS 0 VDD FF ADG5412F
VRESET RESET 0 PWL(0 3.3 40m 3.3 40.001m 0)
RFF VLOG FF 10k
CC PRE RX_IN 1u
RINPUT RX_IN 0 100k
CINPUT RX_IN 0 10p
DZ TOP CLAMP_MID SMBJ28A_APPROX
DFLY BOTTOM CLAMP_MID US1D_APPROX
CPAR COIL_TOP BOTTOM {CP}
.include "vendor/selected_diodes.lib"
VPOL POL 0 PWL(0 0 5m 0 5.001m 5 25m 5 25.001m 0)
VTOP TG 0 PWL(0 5 4.9m 5 4.901m 0 25.1m 0 25.101m 5)
VDAMP DP 0 PWL(0 3.3 37m 3.3 37.001m 0)
VSHUNT SH 0 PWL(0 3.3 38.98m 3.3 38.981m 0)
VRX RX 0 PWL(0 0 39m 0 39.001m 3.3)
.lib "vendor/ADG5412F.sub"
.lib "vendor/LTC1693-1.sub"
.lib "vendor/LTC1693-5.sub"
.options plotwinsize=0 method=gear
.tran 0 70m 0 100n
.save V(VBAT) V(TOP) V(BOTTOM) V(PRE) V(RX_IN) V(G1) V(G4) V(G5) I(LCOIL) I(VBAT) V(FF) I(M4) I(M1) I(M5)
.meas TRAN I_POL FIND I(LCOIL) AT=24m
.meas TRAN BOTTOM_MAX MAX V(BOTTOM)
.meas TRAN BOTTOM_MIN MIN V(BOTTOM)
.meas TRAN TOP_MIN MIN V(TOP)
.meas TRAN RX_BLANK MAX abs(V(RX_IN)) FROM 0 TO 38.98m
.meas TRAN RX_ACQ MAX abs(V(RX_IN)) FROM 60m TO 70m
.meas TRAN G1_MAX MAX V(G1)
.meas TRAN G4_MIN MIN V(G4,VBAT)
.meas TRAN G4_MAX MAX V(G4,VBAT)
.meas TRAN I_SUPPLY_MAX MAX (-I(VBAT))
.model IRF530 VDMOS(Rg=3 Vto=4 Rd=50m Rs=12m Rb=60m Kp=5 lambda=.01 Cgdmax=1n Cgdmin=.26n Cgs=.2n Cjo=.4n Is=52p ksubthres=.1 mfg=International_Rectifier Vds=100 Ron=160m Qg=26n)
.model IRF9640 VDMOS(pchan Rg=3 Vto=-3.5 Rd=.15 Rs=.15 Rb=.15 Kp=8 lambda=.01 mtriode=.5 Cgdmax=1.5n Cgdmin=.07n Cgs=1n Cjo=1n Is=38p ksubthres=.1 mfg=International_Rectifier Vds=-200 Ron=.5 Qg=44n)

* Series coil-current monitor, included in both polarization and discharge loops.
RSHUNT TOP COIL_TOP 0.25
XCS CS_OUT TOP COIL_TOP VLOG 0 V5 0 INA241_LOCAL
CCS V5 0 100n
RADC CS_OUT I_ADC 1k
CADC I_ADC 0 10n
RADCLOAD I_ADC 0 1.5k
.include "vendor/ina241_adapter.lib"
.save V(COIL_TOP) V(CS_OUT) V(I_ADC) V(VLOG) I(RSHUNT)
.meas TRAN ADC_24 FIND V(I_ADC) AT=24m
.meas TRAN SHUNT_24 FIND I(RSHUNT) AT=24m
.meas TRAN SHUNT_POWER_24 FIND (V(TOP,COIL_TOP)*I(RSHUNT)) AT=24m

V5 V5 0 5
.end
